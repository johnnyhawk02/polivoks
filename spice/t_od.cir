* Overdrive: 300 Hz sine into the mixer input, Iset 1 uA each (f0 ~1.2 kHz), res 0.5
.include models.lib
.param pr=0.5 icol=2u amp=1 fr=300
.include core.inc
VIN in 0 SIN(0 {amp} {fr})
ICOL col 0 {icol}
.options reltol=1e-4
.control
foreach f 300 2400
foreach a 0.5 2 5 10
  alterparam amp=$a
  alterparam fr=$f
  reset
  tran 2u 60m 0 2u
  linearize v(lp) v(bp)
  fourier $f v(lp)
  meas tran lrms rms v(lp) from=40m to=60m
  meas tran lpk max v(lp) from=40m to=60m
  meas tran lmn min v(lp) from=40m to=60m
  meas tran brms rms v(bp) from=40m to=60m
  meas tran lav avg v(lp) from=40m to=60m
  echo "D $f $a $&lrms $&lav"
end
end
.endc
.end
