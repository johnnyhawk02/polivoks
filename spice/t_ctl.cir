* Cutoff control law: knob position -> V1 collector current (both Iset pins)
.include models.lib
.param pr=0.5 pc=0.5 venv=0
.include core.inc
.include ctl.inc
VIN in 0 0
.control
foreach p 0 0.02 0.04 0.06 0.08 0.1 0.12 0.15 0.2 0.25 0.3 0.4 0.5 0.7 1
  alterparam pc=$p
  reset
  op
  let ic=-i(vp)
  echo "C $p $&@qv1[ic] $&v(a1o) $&v(col) $&v(iset2)"
end
.endc
.end
